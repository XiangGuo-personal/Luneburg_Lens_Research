# Ansys Electronics Desktop project, version 2019.2
materials:
  vacuum: permittivity=1
  Rogers RT/duroid 5880 (tm): permittivity=2.2 dielectric_loss_tangent=0.0009
  copper: permeability=0.999991 conductivity=58000000

design HFSSDesign1 (HFSS, DrivenModal, model units mm)
variables:
  lx9a = lx9-4*g
  a = 0.14
  lx = 3.6mm
  lx5 = 6.1mm
  g = 0.1mm
  h = 2.36mm
  lx5a = lx5-4*g
  lx7a = lx7-4*g
  yr7 = a*lx7
  lx3 = 5.65mm
  yr5 = a*lx5
  yr4 = a*lx4
  lx1 = lx-4*g
  lx4 = 5.93mm
  lx6a = lx6-4*g
  lx8 = 7mm
  lx3a = lx3-4*g
  yr8 = a*lx8
  yr3 = a*lx3
  lx8a = lx8-4*g
  yr2 = a*lx2
  yr9 = a*lx9
  w = 0.8mm
  yr6 = a*lx6
  p = 9mm
  lx9 = 8.2mm
  lx6 = 6.3mm
  hm = 0.05mm
  lx2a = lx-4*g
  yr = a*lx
  lx7 = 6.6mm
  lx2 = 5mm
  lx4a = lx4-4*g
geometry:
  d1_down [copper] = box(corner=(-0.5*lx1, -0.5*w, 0mm), size=(lx1, w, hm))
  Box4_1 = d1_down.duplicate_around_axis(axis=Z, angle=90deg, total=2)
  d1_down.unite(Box4_1)
  Box4_2 = d1_down.duplicate_along_line(step=(0mm, 0mm, -h-hm), total=2)
  ring = box(corner=(-0.5*lx, -0.5*(w+4*g), 0mm), size=(lx, w+4*g, 0.05mm))
  Box5_1 = ring.duplicate_around_axis(axis=Z, angle=90deg, total=2)
  ring.unite(Box5_1)
  Box6 = box(corner=(-0.5*(lx1+2*g), -0.5*(w+2*g), 0mm), size=(lx1+2*g, w+2*g, 0.05mm))
  Box6_1 = Box6.duplicate_around_axis(axis=Z, angle=90deg, total=2)
  Box6.unite(Box6_1)
  ring.subtract(Box6)
  ring_1 = ring.duplicate_along_line(step=(0mm, 0mm, -h-hm), total=2)
  d1_down.unite(Box4_2, ring, ring_1)
  Cylinder1 = cylinder(axis=Z, base_centre=(0mm, yr, hm), radius=0.15mm, height=-h-2*hm)
  Cylinder1_1, Cylinder1_2, Cylinder1_3 = Cylinder1.duplicate_around_axis(axis=Z, angle=90deg, total=4)
  Cylinder1.unite(Cylinder1_1, Cylinder1_2, Cylinder1_3)
  d1_down.unite(Cylinder1)
  d1_down.move(-2*p, 0.5*p, 0mm)
  d1_down.duplicate_along_line(step=(0mm, p, 0mm), total=5, attached)
  d3 = box(corner=(-0.5*lx3a, -0.5*w, 0mm), size=(lx3a, w, hm))
  Box4_3 = d3.duplicate_around_axis(axis=Z, angle=90deg, total=2)
  d3.unite(Box4_3)
  Box4_4 = d3.duplicate_along_line(step=(0mm, 0mm, -h-hm), total=2)
  ring1 = box(corner=(-0.5*lx3, -0.5*(w+4*g), 0mm), size=(lx3, w+4*g, 0.05mm))
  Box5_2 = ring1.duplicate_around_axis(axis=Z, angle=90deg, total=2)
  ring1.unite(Box5_2)
  Box8 = box(corner=(-0.5*(lx3a+2*g), -0.5*(w+2*g), 0mm), size=(lx3a+2*g, w+2*g, 0.05mm))
  Box6_2 = Box8.duplicate_around_axis(axis=Z, angle=90deg, total=2)
  Box8.unite(Box6_2)
  ring1.subtract(Box8)
  ring_2 = ring1.duplicate_along_line(step=(0mm, 0mm, -h-hm), total=2)
  d3.unite(Box4_4, ring1, ring_2)
  Cylinder2 = cylinder(axis=Z, base_centre=(0mm, yr3, hm), radius=0.15mm, height=-h-2*hm)
  Cylinder1_4, Cylinder1_5, Cylinder1_6 = Cylinder2.duplicate_around_axis(axis=Z, angle=90deg, total=4)
  Cylinder2.unite(Cylinder1_4, Cylinder1_5, Cylinder1_6)
  d3.unite(Cylinder2)
  d3.move(-p, 0.5*p, 0mm)
  d3.duplicate_along_line(step=(0mm, p, 0mm), total=5, attached)
  d5 = box(corner=(-0.5*lx5a, -0.5*w, 0mm), size=(lx5a, w, hm))
  Box4_5 = d5.duplicate_around_axis(axis=Z, angle=90deg, total=2)
  d5.unite(Box4_5)
  Box4_6 = d5.duplicate_along_line(step=(0mm, 0mm, -h-hm), total=2)
  ring2 = box(corner=(-0.5*lx5, -0.5*(w+4*g), 0mm), size=(lx5, w+4*g, 0.05mm))
  Box5_3 = ring2.duplicate_around_axis(axis=Z, angle=90deg, total=2)
  ring2.unite(Box5_3)
  Box9 = box(corner=(-0.5*(lx5a+2*g), -0.5*(w+2*g), 0mm), size=(lx5a+2*g, w+2*g, 0.05mm))
  Box6_3 = Box9.duplicate_around_axis(axis=Z, angle=90deg, total=2)
  Box9.unite(Box6_3)
  ring2.subtract(Box9)
  ring_3 = ring2.duplicate_along_line(step=(0mm, 0mm, -h-hm), total=2)
  d5.unite(Box4_6, ring2, ring_3)
  Cylinder3 = cylinder(axis=Z, base_centre=(0mm, yr5, hm), radius=0.15mm, height=-h-2*hm)
  Cylinder1_7, Cylinder1_8, Cylinder1_9 = Cylinder3.duplicate_around_axis(axis=Z, angle=90deg, total=4)
  Cylinder3.unite(Cylinder1_7, Cylinder1_8, Cylinder1_9)
  d5.unite(Cylinder3)
  d5.move(0, 0.5*p, 0mm)
  d5.duplicate_along_line(step=(0mm, p, 0mm), total=5, attached)
  d7 = box(corner=(-0.5*lx7a, -0.5*w, 0mm), size=(lx7a, w, hm))
  Box4_7 = d7.duplicate_around_axis(axis=Z, angle=90deg, total=2)
  d7.unite(Box4_7)
  Box4_8 = d7.duplicate_along_line(step=(0mm, 0mm, -h-hm), total=2)
  ring3 = box(corner=(-0.5*lx7, -0.5*(w+4*g), 0mm), size=(lx7, w+4*g, 0.05mm))
  Box5_4 = ring3.duplicate_around_axis(axis=Z, angle=90deg, total=2)
  ring3.unite(Box5_4)
  Box10 = box(corner=(-0.5*(lx7a+2*g), -0.5*(w+2*g), 0mm), size=(lx7a+2*g, w+2*g, 0.05mm))
  Box6_4 = Box10.duplicate_around_axis(axis=Z, angle=90deg, total=2)
  Box10.unite(Box6_4)
  ring3.subtract(Box10)
  ring_4 = ring3.duplicate_along_line(step=(0mm, 0mm, -h-hm), total=2)
  d7.unite(Box4_8, ring3, ring_4)
  Cylinder4 = cylinder(axis=Z, base_centre=(0mm, yr7, hm), radius=0.15mm, height=-h-2*hm)
  Cylinder1_10, Cylinder1_11, Cylinder1_12 = Cylinder4.duplicate_around_axis(axis=Z, angle=90deg, total=4)
  Cylinder4.unite(Cylinder1_10, Cylinder1_11, Cylinder1_12)
  d7.unite(Cylinder4)
  d7.move(p, 0.5*p, 0mm)
  d7.duplicate_along_line(step=(0mm, p, 0mm), total=5, attached)
  d9 = box(corner=(-0.5*lx9a, -0.5*w, 0mm), size=(lx9a, w, hm))
  Box4_9 = d9.duplicate_around_axis(axis=Z, angle=90deg, total=2)
  d9.unite(Box4_9)
  Box4_10 = d9.duplicate_along_line(step=(0mm, 0mm, -h-hm), total=2)
  ring4 = box(corner=(-0.5*lx9, -0.5*(w+4*g), 0mm), size=(lx9, w+4*g, 0.05mm))
  Box5_5 = ring4.duplicate_around_axis(axis=Z, angle=90deg, total=2)
  ring4.unite(Box5_5)
  Box11 = box(corner=(-0.5*(lx9a+2*g), -0.5*(w+2*g), 0mm), size=(lx9a+2*g, w+2*g, 0.05mm))
  Box6_5 = Box11.duplicate_around_axis(axis=Z, angle=90deg, total=2)
  Box11.unite(Box6_5)
  ring4.subtract(Box11)
  ring_5 = ring4.duplicate_along_line(step=(0mm, 0mm, -h-hm), total=2)
  d9.unite(Box4_10, ring4, ring_5)
  Cylinder5 = cylinder(axis=Z, base_centre=(0mm, yr9, hm), radius=0.15mm, height=-h-2*hm)
  Cylinder1_13, Cylinder1_14, Cylinder1_15 = Cylinder5.duplicate_around_axis(axis=Z, angle=90deg, total=4)
  Cylinder5.unite(Cylinder1_13, Cylinder1_14, Cylinder1_15)
  d9.unite(Cylinder5)
  d9.move(p*2, 0.5*p, 0mm)
  d9.duplicate_along_line(step=(0mm, p, 0mm), total=5, attached)
  d2 = box(corner=(-0.5*lx2a, -0.5*w, 0mm), size=(lx2a, w, hm))
  Box4_11 = d2.duplicate_around_axis(axis=Z, angle=90deg, total=2)
  d2.unite(Box4_11)
  Box4_12 = d2.duplicate_along_line(step=(0mm, 0mm, -h-hm), total=2)
  ring5 = box(corner=(-0.5*lx2, -0.5*(w+4*g), 0mm), size=(lx2, w+4*g, 0.05mm))
  Box5_6 = ring5.duplicate_around_axis(axis=Z, angle=90deg, total=2)
  ring5.unite(Box5_6)
  Box12 = box(corner=(-0.5*(lx2a+2*g), -0.5*(w+2*g), 0mm), size=(lx2a+2*g, w+2*g, 0.05mm))
  Box6_6 = Box12.duplicate_around_axis(axis=Z, angle=90deg, total=2)
  Box12.unite(Box6_6)
  ring5.subtract(Box12)
  ring_6 = ring5.duplicate_along_line(step=(0mm, 0mm, -h-hm), total=2)
  d2.unite(Box4_12, ring5, ring_6)
  Cylinder6 = cylinder(axis=Z, base_centre=(0mm, yr2, hm), radius=0.15mm, height=-h-2*hm)
  Cylinder1_16, Cylinder1_17, Cylinder1_18 = Cylinder6.duplicate_around_axis(axis=Z, angle=90deg, total=4)
  Cylinder6.unite(Cylinder1_16, Cylinder1_17, Cylinder1_18)
  d2.unite(Cylinder6)
  d2.move(p*3, 0.5*p, 0mm)
  d2.duplicate_along_line(step=(0mm, p, 0mm), total=5, attached)
  d4 = box(corner=(-0.5*lx4a, -0.5*w, 0mm), size=(lx4a, w, hm))
  Box4_13 = d4.duplicate_around_axis(axis=Z, angle=90deg, total=2)
  d4.unite(Box4_13)
  Box4_14 = d4.duplicate_along_line(step=(0mm, 0mm, -h-hm), total=2)
  ring6 = box(corner=(-0.5*lx4, -0.5*(w+4*g), 0mm), size=(lx4, w+4*g, 0.05mm))
  Box5_7 = ring6.duplicate_around_axis(axis=Z, angle=90deg, total=2)
  ring6.unite(Box5_7)
  Box13 = box(corner=(-0.5*(lx4a+2*g), -0.5*(w+2*g), 0mm), size=(lx4a+2*g, w+2*g, 0.05mm))
  Box6_7 = Box13.duplicate_around_axis(axis=Z, angle=90deg, total=2)
  Box13.unite(Box6_7)
  ring6.subtract(Box13)
  ring_7 = ring6.duplicate_along_line(step=(0mm, 0mm, -h-hm), total=2)
  d4.unite(Box4_14, ring6, ring_7)
  Cylinder7 = cylinder(axis=Z, base_centre=(0mm, yr4, hm), radius=0.15mm, height=-h-2*hm)
  Cylinder1_19, Cylinder1_20, Cylinder1_21 = Cylinder7.duplicate_around_axis(axis=Z, angle=90deg, total=4)
  Cylinder7.unite(Cylinder1_19, Cylinder1_20, Cylinder1_21)
  d4.unite(Cylinder7)
  d4.move(p*4, 0.5*p, 0mm)
  d4.duplicate_along_line(step=(0mm, p, 0mm), total=5, attached)
  d6 = box(corner=(-0.5*lx6a, -0.5*w, 0mm), size=(lx6a, w, hm))
  Box4_15 = d6.duplicate_around_axis(axis=Z, angle=90deg, total=2)
  d6.unite(Box4_15)
  Box4_16 = d6.duplicate_along_line(step=(0mm, 0mm, -h-hm), total=2)
  ring7 = box(corner=(-0.5*lx6, -0.5*(w+4*g), 0mm), size=(lx6, w+4*g, 0.05mm))
  Box5_8 = ring7.duplicate_around_axis(axis=Z, angle=90deg, total=2)
  ring7.unite(Box5_8)
  Box14 = box(corner=(-0.5*(lx6a+2*g), -0.5*(w+2*g), 0mm), size=(lx6a+2*g, w+2*g, 0.05mm))
  Box6_8 = Box14.duplicate_around_axis(axis=Z, angle=90deg, total=2)
  Box14.unite(Box6_8)
  ring7.subtract(Box14)
  ring_8 = ring7.duplicate_along_line(step=(0mm, 0mm, -h-hm), total=2)
  d6.unite(Box4_16, ring7, ring_8)
  Cylinder8 = cylinder(axis=Z, base_centre=(0mm, yr6, hm), radius=0.15mm, height=-h-2*hm)
  Cylinder1_22, Cylinder1_23, Cylinder1_24 = Cylinder8.duplicate_around_axis(axis=Z, angle=90deg, total=4)
  Cylinder8.unite(Cylinder1_22, Cylinder1_23, Cylinder1_24)
  d6.unite(Cylinder8)
  d6.move(p*5, 0.5*p, 0mm)
  d6.duplicate_along_line(step=(0mm, p, 0mm), total=5, attached)
  d8 = box(corner=(-0.5*lx8a, -0.5*w, 0mm), size=(lx8a, w, hm))
  Box4_17 = d8.duplicate_around_axis(axis=Z, angle=90deg, total=2)
  d8.unite(Box4_17)
  Box4_18 = d8.duplicate_along_line(step=(0mm, 0mm, -h-hm), total=2)
  ring8 = box(corner=(-0.5*lx8, -0.5*(w+4*g), 0mm), size=(lx8, w+4*g, 0.05mm))
  Box5_9 = ring8.duplicate_around_axis(axis=Z, angle=90deg, total=2)
  ring8.unite(Box5_9)
  Box15 = box(corner=(-0.5*(lx8a+2*g), -0.5*(w+2*g), 0mm), size=(lx8a+2*g, w+2*g, 0.05mm))
  Box6_9 = Box15.duplicate_around_axis(axis=Z, angle=90deg, total=2)
  Box15.unite(Box6_9)
  ring8.subtract(Box15)
  ring_9 = ring8.duplicate_along_line(step=(0mm, 0mm, -h-hm), total=2)
  d8.unite(Box4_18, ring8, ring_9)
  Cylinder9 = cylinder(axis=Z, base_centre=(0mm, yr8, hm), radius=0.15mm, height=-h-2*hm)
  Cylinder1_25, Cylinder1_26, Cylinder1_27 = Cylinder9.duplicate_around_axis(axis=Z, angle=90deg, total=4)
  Cylinder9.unite(Cylinder1_25, Cylinder1_26, Cylinder1_27)
  d8.unite(Cylinder9)
  d8.move(-3*p, 0.5*p, 0mm)
  d8.duplicate_along_line(step=(0mm, p, 0mm), total=5, attached)
  d4_1 = box(corner=(-0.5*lx4a, -0.5*w, 0mm), size=(lx4a, w, hm))
  Box4_19 = d4_1.duplicate_around_axis(axis=Z, angle=90deg, total=2)
  d4_1.unite(Box4_19)
  Box4_20 = d4_1.duplicate_along_line(step=(0mm, 0mm, -h-hm), total=2)
  ring9 = box(corner=(-0.5*lx4, -0.5*(w+4*g), 0mm), size=(lx4, w+4*g, 0.05mm))
  Box5_10 = ring9.duplicate_around_axis(axis=Z, angle=90deg, total=2)
  ring9.unite(Box5_10)
  Box19 = box(corner=(-0.5*(lx4a+2*g), -0.5*(w+2*g), 0mm), size=(lx4a+2*g, w+2*g, 0.05mm))
  Box6_10 = Box19.duplicate_around_axis(axis=Z, angle=90deg, total=2)
  Box19.unite(Box6_10)
  ring9.subtract(Box19)
  ring_10 = ring9.duplicate_along_line(step=(0mm, 0mm, -h-hm), total=2)
  d4_1.unite(Box4_20, ring9, ring_10)
  Cylinder10 = cylinder(axis=Z, base_centre=(0mm, yr4, hm), radius=0.15mm, height=-h-2*hm)
  Cylinder1_28, Cylinder1_29, Cylinder1_30 = Cylinder10.duplicate_around_axis(axis=Z, angle=90deg, total=4)
  Cylinder10.unite(Cylinder1_28, Cylinder1_29, Cylinder1_30)
  d4_1.unite(Cylinder10)
  d4_1.move(-5*p, 0.5*p, 0mm)
  d4_1.duplicate_along_line(step=(0mm, p, 0mm), total=5, attached)
  d6_1 = box(corner=(-0.5*lx6a, -0.5*w, 0mm), size=(lx6a, w, hm))
  Box4_21 = d6_1.duplicate_around_axis(axis=Z, angle=90deg, total=2)
  d6_1.unite(Box4_21)
  Box4_22 = d6_1.duplicate_along_line(step=(0mm, 0mm, -h-hm), total=2)
  ring10 = box(corner=(-0.5*lx6, -0.5*(w+4*g), 0mm), size=(lx6, w+4*g, 0.05mm))
  Box5_11 = ring10.duplicate_around_axis(axis=Z, angle=90deg, total=2)
  ring10.unite(Box5_11)
  Box20 = box(corner=(-0.5*(lx6a+2*g), -0.5*(w+2*g), 0mm), size=(lx6a+2*g, w+2*g, 0.05mm))
  Box6_11 = Box20.duplicate_around_axis(axis=Z, angle=90deg, total=2)
  Box20.unite(Box6_11)
  ring10.subtract(Box20)
  ring_11 = ring10.duplicate_along_line(step=(0mm, 0mm, -h-hm), total=2)
  d6_1.unite(Box4_22, ring10, ring_11)
  Cylinder11 = cylinder(axis=Z, base_centre=(0mm, yr6, hm), radius=0.15mm, height=-h-2*hm)
  Cylinder1_31, Cylinder1_32, Cylinder1_33 = Cylinder11.duplicate_around_axis(axis=Z, angle=90deg, total=4)
  Cylinder11.unite(Cylinder1_31, Cylinder1_32, Cylinder1_33)
  d6_1.unite(Cylinder11)
  d6_1.move(-4*p, 0.5*p, 0mm)
  d6_1.duplicate_along_line(step=(0mm, p, 0mm), total=5, attached)
  d1_down.unite(d3, d5, d7, d9, d2, d4, d6, d8, d4_1, d6_1)
  d1_down.move(0mm, 0mm, 15.5mm)
  Box_down [Rogers RT/duroid 5880 (tm)] = box(corner=((-0.5*99) mm, -45mm, 0mm), size=(99mm, 90mm, -2.36mm))
  Box_down.move(0mm, 0mm, 15.5mm)
  d1_down.duplicate_along_line(step=(0mm, -45mm, 0mm), total=2, attached)
